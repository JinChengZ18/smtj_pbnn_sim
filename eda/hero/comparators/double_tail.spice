* Double-tail dynamic comparator (Zhang et al. JPCS 2405:012014 2022), sky130.
* Reproduction-comparison netlist for run_offset_mc.py's netlist factory.
* Shared interface (harness preamble): nodes vdd vss clk vinp vinn, outputs outp outn.
* Stage 1: clk-gated tail + input pair discharging intermediate nodes di/dib
* (precharged high via PMOS when clk low). Stage 2: own clk-gated tail, NMOS input
* pair driven by di/dib, cross-coupled NMOS+PMOS latch; outp/outn precharged low
* by clk-gated PMOS-disable / NMOS reset is via the latch tail being off when clk low.
* META n_off=2 meas_t=3.2n win_default=4.0 wl=win*0.15,win*0.15 desc=Double-tail-charge-steering-Zhang2022
* offset-injection: input pair gates (g1,g2)
Vo1 g1 vinp DC {os0:.6f}
Vo2 g2 vinn DC {os1:.6f}
* ---- Stage 1: pre-amplifier (charge-steering first tail) ----
XMt1   s1    clk   vss   vss sky130_fd_pr__nfet_01v8 W=4 L=0.15
XMin1  di    g1    s1    vss sky130_fd_pr__nfet_01v8 W={win} L=0.15
XMin2  dib   g2    s1    vss sky130_fd_pr__nfet_01v8 W={win} L=0.15
XMpc1  di    clk   vdd   vdd sky130_fd_pr__pfet_01v8 W=2 L=0.15
XMpc2  dib   clk   vdd   vdd sky130_fd_pr__pfet_01v8 W=2 L=0.15
* ---- Stage 2: latch (second tail + cross-coupled NMOS/PMOS) ----
XMt2   s2    clk   vss   vss sky130_fd_pr__nfet_01v8 W=4 L=0.15
XMl1   outn  di    s2    vss sky130_fd_pr__nfet_01v8 W=2 L=0.15
XMl2   outp  dib   s2    vss sky130_fd_pr__nfet_01v8 W=2 L=0.15
XMcn1  outn  outp  s2    vss sky130_fd_pr__nfet_01v8 W=1 L=0.15
XMcn2  outp  outn  s2    vss sky130_fd_pr__nfet_01v8 W=1 L=0.15
XMcp1  outn  outp  vdd   vdd sky130_fd_pr__pfet_01v8 W=2 L=0.15
XMcp2  outp  outn  vdd   vdd sky130_fd_pr__pfet_01v8 W=2 L=0.15
* precharge outp/outn high when clk low (reset)
XMpo1  outp  clk   vdd   vdd sky130_fd_pr__pfet_01v8 W=2 L=0.15
XMpo2  outn  clk   vdd   vdd sky130_fd_pr__pfet_01v8 W=2 L=0.15
