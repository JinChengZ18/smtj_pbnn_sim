* Write-path transient: 0.75 ns write pulse -> delivery across the 776 ohm SOT branch ->
* instantaneous switching probability P_sw(t) from the calibrated smtj_sot compact model (OSDI).
* Needs .spiceinit in cwd (osdi smtj_sot.osdi).
.model smtj_sot smtj_sot
.param Vamp=0.90 Rdrv=10 Cwr=5f tw=0.75n tr=0.05n
Vpulse drvin 0 PULSE(0 {Vamp} 0.2n {tr} {tr} {tw} 10n)
Rdrv drvin wr {Rdrv}
Cwr  wr 0 {Cwr}
Vcom com 0 dc 0
Vrd  rd  0 dc 0
Vst  st  0 dc 0
N1 wr rd com st psw tau sinf smtj_sot
Rpsw  psw  0 1e12
Rtau  tau  0 1e12
Rsinf sinf 0 1e12
.control
  tran 0.5p 4n
  wrdata write_tran.csv v(drvin) v(wr) v(psw)
  quit
.endc
.end
